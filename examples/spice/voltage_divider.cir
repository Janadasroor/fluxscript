* Voltage Divider
R1 1 2 1k
R2 2 0 2k
V1 1 0 5
