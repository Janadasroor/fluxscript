NPN BJT DC bias (weak base drive, active region)
Vcc 1 0 5
Rb 1 2 100k
Rc 1 3 1k
Q1 3 2 0 1e-14 100 50
