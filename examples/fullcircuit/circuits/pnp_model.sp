PNP common-emitter with .model card
.MODEL MYPNP PNP(IS=1e-14 BF=100 VAF=50)
Vcc 1 0 5
Re 1 3 1k
Rb 2 0 100k
Rc 4 0 1k
Q1 4 2 3 MYPNP
