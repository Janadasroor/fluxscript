NMOS Switch circuit
Vdd 1 0 5
Vgg 2 0 3.3
Rd 1 3 1k
M1 3 2 0 0 1e-4 1 0.01
