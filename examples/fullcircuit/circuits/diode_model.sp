Diode bias with .model card
.MODEL D1N4148 D(IS=2.52e-9 NF=1.75)
Vdd 1 0 5
R1 1 2 1k
D1 2 0 D1N4148
