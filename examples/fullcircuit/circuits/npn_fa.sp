NPN forward-active DC bias (no saturation)
Vcc 1 0 10
Rb 1 2 100k
Rc 1 3 100
Q1 3 2 0 1e-14 100 50
