* Test Circuit 10: DC Sweep - Diode IV Curve
Vin in 0 DC=0
R1 in out 100
D1 out 0 1N4148
.model 1N4148 D(Is=2.52n N=1.752)
.dc Vin 0 1 0.01
.END
