* Test Circuit 4: RLC Bandpass Filter
Vin in 0 AC=1 SIN(0 1 1000)
R1 in out 100
L1 out n1 10mH
C1 n1 0 100nF
.tran 10u 5m
.ac dec 10 100 1Meg
.END
