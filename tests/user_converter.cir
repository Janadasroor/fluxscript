* viospice Automated Hierarchical SPICE Netlist
* Generated: 2026-04-15T15:59:44
.options ngbehavior=ltps
* Custom SPICE Directives
.model Vm VDMOS(Rg=1.3 Vto=4.25 Rd=4.47m Rs=450u Rb=1.16m Kp=56.1 Lambda=0.03 Cgdmin=24p Cgdmax=0.7n A=0.3 Cgs=2.13n Cjo=2.24n M=0.35 Is=21.3p VJ=0.8 N=1.11 TT=90n ksubthres=.1 mfg=Infineon Vds=100 Ron=10m Qg=33n)
.tran 1e-05 0.002 0
K12 L1 L2 0.999
K13 L1 L3 0.999
K14 L1 L4 0.999
K23 L2 L3 0.999
K24 L2 L4 0.999
K34 L3 L4 0.999

* Embedded Models
.model BSC042N03MS NMOS(KP=291.5 LAMBDA=0.07 RD=0.00218 RG=1.5 RS=0.000571 VTO=2.52)
.model 30BQ060 D(CJO=1.8e-10 IS=1e-05 N=1.4 RS=0.04)

D1 Net1 Net2 30BQ060
D4 Net3 Net2 30BQ060
R__RSER_L2 0 L2__rser 50m
R__RPAR_L2 L2__rser Net3 100Meg
C__CPAR_L2 L2__rser Net3 1p
L2 L2__rser Net3 4m ic=0
R__RSER_L3 Net4 L3__rser 50m
R__RPAR_L3 L3__rser Net5 100Meg
C__CPAR_L3 L3__rser Net5 1p
L3 L3__rser Net5 1m ic=0
R__RSER_L4 Net5 L4__rser 50m
R__RPAR_L4 L4__rser Net6 100Meg
C__CPAR_L4 L4__rser Net6 1p
L4 L4__rser Net6 1m ic=0
R1 0 Net2 100
V1 Net5 0 12
MN3 Net4 G1 0 0 BSC042N03MS
MN2 Net6 G2 0 0 BSC042N03MS
V2 G1 0 PULSE(0.0 10 0.05m 1n 1n 0.049m 0.1m 0)
V3 G2 0 PULSE(0.0 10 0 1n 1n 0.049m 0.1m 0)
R__RSER_L1 Net1 L1__rser 50m
R__RPAR_L1 L1__rser 0 100Meg
C__CPAR_L1 L1__rser 0 1p
L1 L1__rser 0 4m ic=0
C1 Net2 0 1m
D3 Net1 Net2 30BQ060
D2 Net1 Net2 30BQ060

.save V(Net2)
.control
set ngbehavior=ltps
run
meas tran vavg avg v(net2) from 0.001 to 0.002
print vavg
quit
.endc
.end
